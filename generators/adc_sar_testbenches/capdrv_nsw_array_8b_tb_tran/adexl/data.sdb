ADE simulation setup
Run mode: Single Run, Sweeps and Corners
Tests:
  adc_sar_testbenches:capdrv_nsw_array_8b_tb_tran:1: adc_sar_testbenches/capdrv_nsw_array_8b_tb_tran/schematic, simulator spectre
Global variables:
  pc0 = 200a
  pc1 = 400a
  pc2 = 800a
  pc3 = 1.6f
  pc4 = 3.2f
  pc5 = 6.4f
  pc6 = 12.8f
  pc7 = 25.6f
  ptrf = 10p
  pvdd = 0.8
  pvh = 0.2
  pvcm = 0.1
  pvl = 0
  tstep = 1p
