ADE simulation setup
Run mode: Single Run, Sweeps and Corners
Tests:
  adc_sar_testbenches:sar_9b_tb_tran:1: adc_sar_testbenches/sar_9b_tb_tran/schematic, simulator spectre
Global variables:
  pdelay = 1n
  pper = 1n
  pskew_rst = 0
  pvdd = 0.8
  pvicm = 100m
  pvidm = {From/To}Auto:-320m:2001:320m{From/To}
  pvref0 = 0.0
  pvref1 = 0.15
  pvref2 = 0.3
  pc0 = 2f
