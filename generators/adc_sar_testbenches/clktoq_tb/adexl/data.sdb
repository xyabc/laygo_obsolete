ADE simulation setup
Run mode: Single Run, Sweeps and Corners
Tests:
  adc_sar_testbenches:clktoq_tb:1: adc_sar_testbenches/clktoq_tb/schematic, simulator spectre
Global variables:
  cl_data = 1.7f, 3.2f, 6.3f, 12.5f, 24.9f, 49.6f, 99.1f
  cl = 10f
  duty = 0.125
  tper = 800p
  tr = 20p
  vdd = 800m
Corners (nominal off):
  model folders: /tools/tstech16/CLN16FFC/PDK/models
  tt: temperature=25; vdd=0.8; toplevel.scs[top_tt]
  ssgnp072v125c: temperature=125; vdd=0.72; toplevel.scs[top_ss]
  ssgnp072v0c: temperature=0; vdd=0.72; toplevel.scs[top_ss]
  ffgnp0p88v125c: temperature=125; vdd=0.88; toplevel.scs[top_ff]
  ffgnp88v0c: temperature=0; vdd=0.88; toplevel.scs[top_ff]
